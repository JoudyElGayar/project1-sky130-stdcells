* ============================================================
*  Quick invx1 test — single midpoint sim
*  Run from the netlists/ folder:
*    ngspice -b test_inv_fixed.spice
* ============================================================
.temp 25
.include "sky130_params.spice"
.include "/Users/joudy/.volare/volare/sky130/versions/de752ec0ba4da0ecb1fbcd309eeec4993d88f5bc/sky130A/libs.ref/sky130_fd_pr/spice/sky130_fd_pr__nfet_01v8__tt.pm3.spice"
.include "/Users/joudy/.volare/volare/sky130/versions/de752ec0ba4da0ecb1fbcd309eeec4993d88f5bc/sky130A/libs.ref/sky130_fd_pr/spice/sky130_fd_pr__pfet_01v8__tt.pm3.spice"
.include "stdcells.spice"

* Supply
VVDD VDD GND 1.8

* Input pulse: tin=0.1225ns (midpoint), starts at 0.245ns
* PULSE(V0 V1 Tdelay Trise Tfall Tpw Tperiod)
VIN A GND PULSE(0 1.8 0.245n 0.1225n 0.1225n 0.6125n 2n)

* Load cap: midpoint cload=0.0094pF
CL Z GND 0.0094p

* Cell under test
XCELL A Z VDD GND invx1

* Transient: 1p step, 5n total
.tran 1p 5n

* ── Measurements ─────────────────────────────────────────────
* VTH  = 0.5 * 1.8 = 0.9V
* V20% = 0.2 * 1.8 = 0.36V
* V80% = 0.8 * 1.8 = 1.44V
*
* INV is inverting: input FALL -> output RISE (cell_rise)
*                   input RISE -> output FALL (cell_fall)

.measure TRAN cell_rise
+ TRIG v(A) VAL=0.9 FALL=1
+ TARG v(Z) VAL=0.9 RISE=1

.measure TRAN cell_fall
+ TRIG v(A) VAL=0.9 RISE=1
+ TARG v(Z) VAL=0.9 FALL=1

.measure TRAN rise_transition
+ TRIG v(Z) VAL=0.36 RISE=1
+ TARG v(Z) VAL=1.44 RISE=1

.measure TRAN fall_transition
+ TRIG v(Z) VAL=1.44 FALL=1
+ TARG v(Z) VAL=0.36 FALL=1

.end
